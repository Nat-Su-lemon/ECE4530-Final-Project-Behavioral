// ============================================================================
// tb_L2_T1_startup.scs  -  T1 start-up, switched model (L2)
// Stimulus : Vin steps 0 -> VIN_FINAL (try 0.6, 1.8, 3.0), 20 mA resistive load
// Look at  : first pulses after fault clears (must start with Phi1), inrush,
//            Vout settling, NOV_CHECK / SW_CHECK = 0 violations in the log
// Note     : switched sims are slow (every clock edge is simulated). Keep TSTOP short.
// ============================================================================
simulator lang=spectre
include "common_params.scs"
parameters VIN_FINAL=1.8 TSTOP=300u RLOAD=50

Vin (vin 0) vsource type=pwl wave=[0 0  10u 0  11u VIN_FINAL]
include "l2_core.scs"

tran1 tran stop=TSTOP errpreset=moderate
